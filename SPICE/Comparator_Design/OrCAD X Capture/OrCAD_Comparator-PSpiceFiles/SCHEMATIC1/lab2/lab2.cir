** Profile: "SCHEMATIC1-lab2"  [ C:\Users\tsao2\Documents\Analog-Comparator-IC-Design\SPICE\Comparator_Design\OrCAD X Capture\orcad_comparator-pspicefiles\schematic1\lab2.sim ]

** Creating circuit file "lab2.cir"
** WARNING: THIS AUTOMATICALLY GENERATED FILE MAY BE OVERWRITTEN BY SUBSEQUENT SIMULATIONS

*Libraries:
* Profile Libraries :
* Local Libraries :
.LIB "../../../orcad_comparator-pspicefiles/orcad_comparator.lib"
* From [PSPICE NETLIST] section of C:\Users\tsao2\cdssetup\OrCAD_PSpice\24.1.0\PSpice.ini file:
.lib "nom.lib"

*Analysis directives:
.TRAN  0 0.1 0
.OPTIONS ADVCONV
.PROBE64 V(alias(*)) I(alias(*)) W(alias(*)) D(alias(*)) NOISE(alias(*))
.INC "..\SCHEMATIC1.net"

.END
