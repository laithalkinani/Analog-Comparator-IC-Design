** Profile: "SCHEMATIC1-dc_gsweep"  [ C:\Users\alkinanl\Desktop\Analog-Comparator-IC-Design\SPICE\Comparator_Design\OrCAD X Capture\OrCAD_Comparator-PSpiceFiles\SCHEMATIC1\dc_gsweep.sim ]

** Creating circuit file "dc_gsweep.cir"
** WARNING: THIS AUTOMATICALLY GENERATED FILE MAY BE OVERWRITTEN BY SUBSEQUENT SIMULATIONS

*Libraries:
* Profile Libraries :
* Local Libraries :
.LIB "../../../orcad_comparator-pspicefiles/orcad_comparator.lib"
* From [PSPICE NETLIST] section of C:\Users\alkinanl\cdssetup\OrCAD_PSpice\24.1.0\PSpice.ini file:
.lib "nom.lib"

*Analysis directives:
.DC LIN V_V1 0 3 0.2
.OPTIONS ADVCONV
.PROBE64 V(alias(*)) I(alias(*)) W(alias(*)) D(alias(*)) NOISE(alias(*))
.INC "..\SCHEMATIC1.net"

.END
